* Non-inverting op-amp diode clipper (TS808 values), ideal op-amp: the
* inverting node is held at the input (E1/E2), and the ground leg's
* current (4.7k + 47n, sensed by VS) is pushed into the output node (F1),
* so it flows through the feedback network: 51k || 51p || an antiparallel
* 1N4148 pair (ideal junctions). Input 0.5 V peak, 1 kHz. Output: out.
V1 in 0 DC 0 SIN(0 0.5 1k)
E1 inm 0 in 0 1
R1 inm s 4.7k
VS s g 0
C1 g 0 47n
E2 fb 0 in 0 1
F1 0 out VS 1
RF out fb 51k
CF out fb 51p
D1 out fb DI
D2 fb out DI
.model DI D(Is=2.52n N=1.752)
.options interp reltol=1e-9 abstol=1e-15 vntol=1e-12 gmin=1e-18
.tran 20.8333333u 10m 0 1u
.control
set wr_singlescale
set numdgt=12
run
wrdata OUTFILE v(out)
.endc
.end
