* BZX84C6V2L I-V curve: a ramp -12 V -> +2 V over 20 ms through 1k into
* the diode (quasi-static: no reactive parts), forward conduction and
* reverse breakdown. The card is LTspice standard.dio (onsemi)'s,
* its static parameters only (left out: Cjo=185p). Output: the diode's voltage.
V1 in 0 PWL(0 -12 20m 2)
R1 in a 1k
D1 a 0 BZX84C6V2L
.model BZX84C6V2L D(Is=1.5n Rs=.5 nbv=3 bv=6.2 Ibv=1m)
.options interp reltol=1e-9 abstol=1e-12 vntol=1e-9
.tran 20.8333333u 20m 0 1u
.control
set wr_singlescale
set numdgt=12
run
wrdata OUTFILE v(a)
.endc
.end
