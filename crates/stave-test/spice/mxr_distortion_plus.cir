* MXR Distortion+ (M-104, 1978), input jack to output, distortion and output at maximum.
* Guitar 100 mV at 1 kHz into a gain of 214: the 741 rails and slews, the germanium pair clips.
* Sources: ElectroSmash, "MXR Distortion + Analysis",
* https://www.electrosmash.com/mxr-distortion-plus-analysis (its
* schematic and parts list; the values below); Aion FX, "Aphelion" build
* documentation (Distortion+ values, schematic p. 7, and its note that the
* Distortion+ had no feedback capacitor), https://aionfx.com.
* Input: C1 1n to ground, C2 10n / R1 10k into the + input, R2 1M to the
* 4.5 V reference. The reference: R6 / R7 1M from the 9 V supply, C6 1u
* to ground. U1, a 741 non-inverting stage: R4 1M output to inverting
* input; C3 47n, R3 4k7 and the 1M distortion pot (a rheostat) from there
* to ground. Out: C4 1u, R5 10k into the D1/D2 pair and C5 1n to ground,
* the 10k output pot a divider (its wiper the output) into an amplifier's
* 1M input. Pots as fractions of the track (their tapers not modelled):
* distortion 1 (the rheostat at its 1 ohm end), output 1 (1 ohm above the wiper, 10k below). The MXR's 1N270 germanium diodes have no published card: the
* 1N34A (ElectroSmash's schematic draws it; the community-extended
* LTspice standard.dio card, static part, diode::Shockley::N34A) stands
* in. The op-amp is stave's opamp::Macromodel::LM741 between 0 and 9 V,
* written as behavioural sources (see opamp_slew.cir). Supply ideal 9 V.
* Output: out.
.param cc=1e-9 vos=2e-3 vhi=8 vlo=1 vmid=4.5 vk=0.02 kc=10
.param gm={6.283185307179586*1.17e6*1e-9} isl={0.5e6*1e-9} g0={gm/200e3}
VIN in 0 SIN(0 0.1 1k)
VA va 0 9
R6 va vb 1meg
R7 vb 0 1meg
C6 vb 0 1u
C1 in 0 1n
C2 in a 10n
R1 a p 10k
R2 vb p 1meg
BG1 0 n1 I = {isl*tanh(gm*(V(p,m)+vos)/isl) + g0*vmid - kc*isl*(max((V(n1)-vhi)/vk,0) + ln(1+exp(-abs((V(n1)-vhi)/vk))) - max((vlo-V(n1))/vk,0) - ln(1+exp(-abs((vlo-V(n1))/vk))))}
RG1 n1 0 {1/g0}
CC1 n1 0 {cc}
EO1 o 0 n1 0 1
R4 o m 1meg
C3 m g 47n
R3 g h 4.7k
RD h 0 1
C4 o q 1u
R5 q d 10k
C5 d 0 1n
D1 d 0 D1N34A
D2 0 d D1N34A
RV1 d out 1
RV2 out 0 10k
RL out 0 1meg
.model D1N34A D(IS=2.6u RS=6.5 N=1.6 BV=25 IBV=0.003)
* ngspice's starting guess for the operating point; stave ignores it.
.nodeset v(vb)=4.5 v(p)=4.5 v(m)=4.5 v(n1)=4.5 v(o)=4.5
.options interp reltol=1e-8 abstol=1e-15 vntol=1e-12
.tran 20.8333333u 10m 0 0.1u
.control
set wr_singlescale
set numdgt=12
run
wrdata OUTFILE v(out)
.endc
.end
