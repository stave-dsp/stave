* spice/big_muff_tone_stack.cir in the time domain (DSP.md R3): the same network
* from rest, driven by 0.5 V at 220 Hz plus 0.5 V at 3.1 kHz (two sines
* in series), so the step into the tones and the steady state both
* read against ngspice's transient. Output: the AC deck's node.
VI i x SIN(0 0.5 220)
V2 x 0 SIN(0 0.5 3.1k)
R19 i lp 33k
C11 lp 0 12n
C10 i hp 3.9n
R18 hp 0 33k
RT1 lp w 50k
RT2 w hp 50k
C12 w b4 100n
R20 b4 0 470k
R21 b4 0 100k
.options interp reltol=1e-6 abstol=1e-15 vntol=1e-9
.tran 20.8333333u 20m 0 1u
.control
set wr_singlescale
set numdgt=12
run
wrdata OUTFILE v(w)
.endc
.end
