* LEDRED I-V curve: a ramp -6 V -> +10 V over 20 ms through 1k into
* the diode (quasi-static: no reactive parts), forward conduction and
* reverse breakdown. The card is the community-extended LTspice standard.dio (Bordodynov), LedRed's,
* its static parameters only (left out: CJO=2.97P VJ=.75 M=.333 TT=4.32U). Output: the diode's voltage.
V1 in 0 PWL(0 -6 20m 10)
R1 in a 1k
D1 a 0 LEDRED
.model LEDRED D(IS=93.2P RS=42M N=3.73 BV=4 IBV=10U)
.options interp reltol=1e-9 abstol=1e-12 vntol=1e-9
.tran 20.8333333u 20m 0 1u
.control
set wr_singlescale
set numdgt=12
run
wrdata OUTFILE v(a)
.endc
.end
