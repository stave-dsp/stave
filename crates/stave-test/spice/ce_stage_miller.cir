* The 2N3904 common-emitter stage of ce_stage.cir rebuilt for gain: the
* emitter bypassed to 10 ohms (gain about 200), driven from 47k, so the
* collector-base capacitance's Miller multiple (~400 pF) with the
* source sets a pole near 90 kHz. A 50 mV, 20 kHz sine. Output: the load.
VIN in 0 SIN(0 50m 20k)
RG in i 47k
C1 i b 1u
R1 vcc b 47k
R2 b 0 10k
Q1 c b e Q2N3904
RE1 e e2 10
RE2 e2 0 1k
CE e2 0 47u
RC vcc c 4.7k
C2 c out 10u
RL out 0 100k
VCC vcc 0 12
.model Q2N3904 NPN(Is=6.734f Xti=3 Eg=1.11 Vaf=74.03 Bf=416.4 Ne=1.259 Ise=6.734f Ikf=66.78m
+ Xtb=1.5 Br=.7371 Nc=2 Isc=0 Ikr=0 Rc=1 Cjc=3.638p Mjc=.3085 Vjc=.75 Fc=.5 Cje=4.493p
+ Mje=.2593 Vje=.75 Tr=239.5n Tf=301.2p Itf=.4 Vtf=4 Xtf=2 Rb=10)
.options interp reltol=1e-9 abstol=1e-15 vntol=1e-12
.tran 20.8333333u 5m 0 0.02u
.control
set wr_singlescale
set numdgt=12
run
wrdata OUTFILE v(out)
.endc
.end
