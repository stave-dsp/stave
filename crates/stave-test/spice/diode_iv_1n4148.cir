* 1N4148 I-V curve: a ramp -5 V -> +5 V over 20 ms through 1k into
* the diode (quasi-static: no reactive parts), forward conduction and
* reverse. The card is LTspice standard.dio (onsemi)'s,
* its static parameters only (left out: Cjo=4p M=.4 tt=20n). Output: the diode's voltage.
V1 in 0 PWL(0 -5 20m 5)
R1 in a 1k
D1 a 0 1N4148
.model 1N4148 D(Is=2.52n Rs=.568 N=1.752)
.options interp reltol=1e-9 abstol=1e-12 vntol=1e-9
.tran 20.8333333u 20m 0 1u
.control
set wr_singlescale
set numdgt=12
run
wrdata OUTFILE v(a)
.endc
.end
