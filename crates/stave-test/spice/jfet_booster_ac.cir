* The J201 booster of jfet_booster.cir, small-signal: |Vout/Vin| and
* its phase from 10 Hz to 100 MHz about the operating point. CGS and
* CGD (3 pF, 1 pF at zero bias) against the 1M gate leak and the 22k
* drain set the top.
VIN in 0 DC 0 AC 1
RG in i 10k
C1 i g 100n
RGL g 0 1meg
J1 d g s J201
RS s 0 1.5k
CS s 0 22u
RD vdd d 22k
C2 d out 1u
RL out 0 100k
VDD vdd 0 9
.model J201 NJF(VTO=-0.90 BETA=7.00E-04 LAMBDA=.035 RD=1.12E+02 RS=1.01E+02 IS=1.58E-16
+ PB=1.00 FC=.5 CGS=3.00E-12 CGD=1.00E-12)
.options reltol=1e-9 abstol=1e-15 vntol=1e-12
.ac dec 20 10 100meg
.control
set wr_singlescale
set numdgt=12
run
wrdata OUTFILE vm(out) vp(out)
.endc
.end
