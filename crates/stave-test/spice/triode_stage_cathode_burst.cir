* spice/triode_stage_cathode.cir through a burst: 4 V at 200 Hz for 50 ms from
* 20 ms (two sines in series, the second cancelling the first from
* 70 ms on), then 180 ms of silence: the bias builds under the burst
* and recovers after (DSP.md R15). Output: the cathode, v(k). The burst
* starts and stops half an output step past 20 and 70 ms, between
* printed points: ngspice interpolates its output linearly across
* the sources' breakpoints, which a printed point on one would read.
.param mu=100 ex=1.4 kg1=1060 kp=600 kvb=300
.param gg=6.177e-4 xi=1.314 cg=9.901 ig0=8.025e-8
V1 in z SIN(0 4 200 20.0104167m)
VOFF z 0 SIN(0 -4 200 70.0104167m)
RS in g 68k
VB b 0 300
RA b p 100k
RK k 0 1579.40
CK k 0 22u
BG g k I = {gg*pow(ln(1+exp(cg*V(g,k)))/cg, xi) + ig0}
BP p k I = {2*pow((V(p,k)/kp)*ln(1+exp(kp*(1/mu+V(g,k)/sqrt(kvb+V(p,k)*V(p,k))))), ex)/kg1}
.options interp reltol=1e-6 abstol=1e-15 vntol=1e-9
.tran 20.8333333u 250m 0 1u
.control
set wr_singlescale
set numdgt=12
run
wrdata OUTFILE v(k)
.endc
.end
