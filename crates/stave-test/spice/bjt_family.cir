* 2N3904 output characteristics: Ic against Vce for base currents of
* 2, 4, 6, 8 and 10 uA (Fairchild's datasheet card, its DC parameters;
* the capacitances are left out, as stave does not model them). Each
* 2 ms segment ramps Vce from 0 to 10 V at one base current; with no
* reactive parts every point is a DC solution. Output: the collector
* current through the 0 V sense source, as 1 V per mA (F1 into 1k).
IB 0 b PWL(0 2u 1.985m 2u 1.995m 4u 3.985m 4u 3.995m 6u 5.985m 6u 5.995m 8u 7.985m 8u 7.995m 10u 10m 10u)
VCE cc 0 PWL(0 0 1.985m 10 1.995m 0 3.985m 10 3.995m 0 5.985m 10 5.995m 0 7.985m 10 7.995m 0 10m 10)
VS cc c 0
Q1 c b 0 Q2N3904
F1 0 s VS 1
RS s 0 1k
.model Q2N3904 NPN(Is=6.734f Bf=416.4 Ne=1.259 Ise=6.734f Ikf=66.78m Br=.7371 Nc=2 Isc=0 Ikr=0 Rc=1 Rb=10 Vaf=74.03)
.options interp reltol=1e-9 abstol=1e-15 vntol=1e-12
.tran 20.8333333u 10m 0 50n
.control
set wr_singlescale
set numdgt=12
run
wrdata OUTFILE v(s)
.endc
.end
