* LEDBLUE I-V curve: a ramp -8 V -> +12 V over 20 ms through 1k into
* the diode (quasi-static: no reactive parts), forward conduction and
* reverse breakdown. The card is the community-extended LTspice standard.dio (Bordodynov), LedBLUE's,
* its static parameters only (left out: CJO=2.97P VJ=.75 M=.333 TT=4.32U). Output: the diode's voltage.
V1 in 0 PWL(0 -8 20m 12)
R1 in a 1k
D1 a 0 LEDBLUE
.model LEDBLUE D(IS=93.2P RS=42M N=7.47 BV=5 IBV=10U)
.options interp reltol=1e-9 abstol=1e-12 vntol=1e-9
.tran 20.8333333u 20m 0 1u
.control
set wr_singlescale
set numdgt=12
run
wrdata OUTFILE v(a)
.endc
.end
