* 1N4148 as a varactor: 5 V of reverse bias through 100k, so the
* junction's depletion capacitance (CJO 4 pF, M 0.4: about 2 pF at
* -5 V) sets a pole near 800 kHz. |Vout/Vin| and its phase from 1 kHz to
* 100 MHz about the operating point (first column = frequency).
VIN in 0 DC 5 AC 1
R1 in out 100k
D1 0 out D1N4148
.model D1N4148 D(Is=2.52n N=1.752 Rs=0.568 Cjo=4p M=0.4 tt=20n)
.options reltol=1e-9 abstol=1e-15 vntol=1e-12
.ac dec 20 1k 100meg
.control
set wr_singlescale
set numdgt=12
run
wrdata OUTFILE vm(out) vp(out)
.endc
.end
