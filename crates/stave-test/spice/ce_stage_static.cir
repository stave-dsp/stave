* The static case: the cards' DC parameters only, as before device
* capacitances (DSP.md R11); the full card is ce_stage.cir.
* Common-emitter gain stage: 2N3904 (Fairchild's card, DC parameters),
* 12 V, 47k/10k base divider, 4.7k collector, 100 ohm emitter
* degeneration over 1k bypassed by 47u, 1u in from a 1k source, 10u out
* into 100k. A 60 mV, 1 kHz sine drives it near clipping (gain ~35).
* Output: the load.
VIN in 0 SIN(0 60m 1k)
RG in i 1k
C1 i b 1u
R1 vcc b 47k
R2 b 0 10k
Q1 c b e Q2N3904
RE1 e e2 100
RE2 e2 0 1k
CE e2 0 47u
RC vcc c 4.7k
C2 c out 10u
RL out 0 100k
VCC vcc 0 12
.model Q2N3904 NPN(Is=6.734f Bf=416.4 Ne=1.259 Ise=6.734f Ikf=66.78m Br=.7371 Nc=2 Isc=0 Ikr=0 Rc=1 Rb=10 Vaf=74.03)
.options interp reltol=1e-9 abstol=1e-15 vntol=1e-12
.tran 20.8333333u 10m 0 0.1u
.control
set wr_singlescale
set numdgt=12
run
wrdata OUTFILE v(out)
.endc
.end
