* Duncan Amps Tone Stack Calculator's default "Fender" preset, which
* matches no real amplifier: AB763 capacitors (250p, 100n, 47n, 100k
* slope) with Bassman pots (bass 1M, mid 25k). For the real stacks see
* tone_stack_fender_5f6a.cir, tone_stack_fender_ab763.cir and
* tone_stack_marshall_2203.cir. The network is Yeh & Smith's (DAFx-06),
* no load: C1 250p, C2 100n, C3 47n, treble 250k, bass 1M, mid 25k,
* slope 100k.
* The treble wiper is the output; the bass pot runs from the treble
* pot's foot to the mid pot's top; C3 lands on the mid pot's wiper.
* Pots: treble 0.2, bass 0.8, mid 0.3. Output |Vo/Vi| over 20 Hz-20 kHz
* (first column = frequency).
VI i 0 DC 0 AC 1
C1 i t 250p
RT1 t o 200000
RT2 o b 50000
R4 i n 100000
C2 n b 100n
RB b j 800000
RM1 j w 17500
RM2 w 0 7500
C3 n w 47n
.ac dec 20 20 20k
.control
set wr_singlescale
set numdgt=12
run
wrdata OUTFILE vm(o)
.endc
.end
