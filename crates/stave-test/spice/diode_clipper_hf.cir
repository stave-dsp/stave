* Diode clipper at 10 kHz: 2 V through 10k into an antiparallel 1N4148
* pair, no shunt capacitor, so the diodes' own charge (depletion and the
* 20 ns transit time's diffusion charge) is all that stores any: their
* recovery shows on every edge. Output: across the pair.
V1 in 0 SIN(0 2 10k)
R1 in out 10k
D1 out 0 D1N4148
D2 0 out D1N4148
.model D1N4148 D(Is=2.52n N=1.752 Rs=0.568 Cjo=4p M=0.4 tt=20n)
.options interp reltol=1e-9 abstol=1e-15 vntol=1e-12
.tran 20.8333333u 2m 0 0.02u
.control
set wr_singlescale
set numdgt=12
run
wrdata OUTFILE v(out)
.endc
.end
